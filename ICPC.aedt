# Ansys Electronics Desktop project, version 2021.1
materials:
  vacuum: permittivity=1
  Ge: permittivity=16
  perfect conductor: conductivity=1e+30
  Ge1: permittivity=16

design Maxwell3DDesign1 (Maxwell 3D, Electrostatic, model units mm)
geometry:
  Cylinder1 [Ge1] = cylinder(axis=Z, base_centre=(0mm, 0mm, 5mm), radius=36.5mm, height=55mm)
  Region [vacuum] = region(percentage_offset=100 on all sides)
  Torus1 = torus(axis=Z, centre=(0mm, 0mm, 5mm), major_radius=32.5mm, minor_radius=4mm)
  Torus2 = torus(axis=Z, centre=(0mm, 0mm, 60mm), major_radius=32.5mm, minor_radius=4mm)
  Cylinder2 = cylinder(axis=Z, base_centre=(0mm, 0mm, 1mm), radius=33.5mm, height=63mm)
  Cylinder1.unite(Cylinder2, Torus1, Torus2)
  Rectangle1 = rectangle(corner=(0mm, 11mm, 65mm), y_size=7mm, z_size=-2mm)
  Circle1 = circle(normal=X, centre=(0mm, 13mm, 63mm), radius=2mm)
  Circle2 = circle(normal=X, centre=(0mm, 16mm, 63mm), radius=2mm)
  Rectangle2 = rectangle(corner=(0mm, 13mm, 61mm), y_size=3mm, z_size=2mm)
  Rectangle1.unite(Circle2, Circle1, Rectangle2)
  Rectangle1.sweep_around_axis(axis=Z, angle=360deg)
  Rectangle1.delete()
  Sphere1 = sphere(centre=(0mm, 0mm, 65mm), radius=1mm)
  Sphere1.delete()
  Cone1 = cone(axis=Z, base_centre=(0mm, 0mm, 0mm), bottom_radius=8mm, top_radius=6mm, height=32mm)
  Sphere2 = sphere(centre=(0mm, 0mm, 32mm), radius=6mm)
  Cone1.unite(Sphere2)
  Cone1.delete()
  Cylinder3 = cylinder(axis=Z, base_centre=(0mm, 0mm, 4mm), radius=37.5mm, height=57mm)
  Cylinder4 = cylinder(axis=Z, base_centre=(0mm, 0mm, 0mm), radius=33.5mm, height=65mm)
  Torus3 = torus(axis=Z, centre=(0mm, 0mm, 4mm), major_radius=33.5mm, minor_radius=4mm)
  Torus4 = torus(axis=Z, centre=(0mm, 0mm, 61mm), major_radius=33.5mm, minor_radius=4mm)
  Cylinder3.unite(Cylinder4, Torus3, Torus4)
  Cylinder3.delete()
  Cylinder7 = cylinder(axis=Z, base_centre=(0mm, 0mm, 64mm), radius=11mm, height=1mm)
  Cylinder1.unite(Cylinder7)
  Cone3 = cone(axis=Z, base_centre=(0mm, 0mm, 0mm), bottom_radius=9mm, top_radius=7mm, height=32mm)
  Sphere6 = sphere(centre=(0mm, 0mm, 32mm), radius=7mm)
  Cone3.unite(Sphere6)
  Rectangle5 = rectangle(corner=(0mm, 11mm, 65mm), y_size=7mm, z_size=-2mm)
  Circle6 = circle(normal=X, centre=(0mm, 16mm, 63mm), radius=2mm)
  Circle5 = circle(normal=X, centre=(0mm, 13mm, 63mm), radius=2mm)
  Rectangle6 = rectangle(corner=(0mm, 13mm, 61mm), y_size=3mm, z_size=2mm)
  Rectangle5.unite(Circle6, Circle5, Rectangle6)
  Rectangle5.sweep_around_axis(axis=Z, angle=360deg)
  Sphere7 = sphere(centre=(0mm, 0mm, 65mm), radius=1mm)
  Sphere7.split(plane=Cylinder1_4.face(4 of 5), keep=PositiveOnly)
  Cylinder8 = cylinder(axis=Z, base_centre=(0mm, 0mm, 4mm), radius=37.5mm, height=57mm)
  Cylinder9 = cylinder(axis=Z, base_centre=(0mm, 0mm, 0mm), radius=33.5mm, height=65mm)
  Torus7 = torus(axis=Z, centre=(0mm, 0mm, 4mm), major_radius=33.5mm, minor_radius=4mm)
  Torus8 = torus(axis=Z, centre=(0mm, 0mm, 61mm), major_radius=33.5mm, minor_radius=4mm)
  Cylinder8.unite(Cylinder9, Torus7, Torus8)
  Cylinder1_4 = Cylinder8.copy()
  [Cylinder8, Cylinder1_4].delete()
  Cylinder1.subtract(Cone3, Rectangle5, Sphere7)
  Cylinder13 = cylinder(axis=Z, base_centre=(0mm, 0mm, 4mm), radius=37.5mm, height=57mm)
  Cylinder14 = cylinder(axis=Z, base_centre=(0mm, 0mm, 0mm), radius=33.5mm, height=65mm)
  Torus11 = torus(axis=Z, centre=(0mm, 0mm, 4mm), major_radius=33.5mm, minor_radius=4mm)
  Torus12 = torus(axis=Z, centre=(0mm, 0mm, 61mm), major_radius=33.5mm, minor_radius=4mm)
  Cylinder13.unite(Cylinder14, Torus11, Torus12)
  Cylinder13.delete()
  Polyline1 [non-model] = polyline((0mm, 0mm, 65mm) (0mm, 0mm, 0mm))
  Sphere3, Cylinder5 [perfect conductor] = imported_body()
boundaries and excitations:
  ground: Voltage Objects=Sphere3 Voltage=0mV
  VolumeChargeDensity1: Volume Charge Density Objects=Cylinder1 Value=-(0.57+5.077*z)*0.001602 CoordinateSystem=Global
  HV: Voltage Objects=Cylinder5 Voltage=2.5kV
parameters:
  Matrix1: Matrix ground, HV: NumberOfTurns=1
mesh:
  initial mesh: GlobalSurfApproximation{CurvedSurfaceApproxChoice=UseSlider SliderMeshSettings=9} GlobalCurvilinear{Apply}
setups:
  Setup1: Electrostatic MaximumPasses=15 MinimumPasses=2 MinimumConvergedPasses=1 PercentRefinement=100 PercentError=0.05 NonLinearResidual=0.001
field plots:
  Voltage1: Voltage in Cylinder1, Cylinder5 on Setup1 : LastAdaptive
